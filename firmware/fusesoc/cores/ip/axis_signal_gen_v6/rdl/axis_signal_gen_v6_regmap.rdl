addrmap axis_signal_gen_v6 {
    name = "AXIS Signal Generator v6 Registers";
    default regwidth = 32;
    default accesswidth = 32;

    reg {
        name = "START_ADDR_REG";
        field { desc = "Envelope write start address."; sw = rw; hw = r; } START_ADDR[31:0] = 0;
    } START_ADDR_REG @ 0x00;

    reg {
        name = "WE_REG";
        field { desc = "Envelope write enable."; sw = rw; hw = r; } WE[0:0] = 0;
    } WE_REG @ 0x04;

    reg {
        name = "RNDQ_REG";
        desc = "Deprecated (rounding-select removed).";
        field { desc = "Deprecated."; sw = rw; hw = r; } RNDQ[31:0] = 0;
    } RNDQ_REG @ 0x08;

    reg {
        name = "STATUS_REG";
        desc = "Status (read-only).";
        field {
            desc = "Sticky saturation flag: 1 = output clamped to +/-MAXV since
                    last clear. Clear via CTRL_REG.SAT_CLEAR.";
            sw = r; hw = w;
        } SATURATING[0:0] = 0;
    } STATUS_REG @ 0x0C;

    reg {
        name = "CTRL_REG";
        desc = "Control.";
        field {
            desc = "Write 1 to clear the sticky saturation flag.";
            sw = rw; hw = r;
        } SAT_CLEAR[0:0] = 0;
    } CTRL_REG @ 0x10;
};