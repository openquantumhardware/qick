addrmap utc_time_regmap {
  regfile {
         default sw = r;
         default hw = w;
         reg {
             field {sticky; onread = rclr;} badframe [ 1] = 0;
             field {sticky; onread = rclr;} timeout  [ 1] = 0;
             field {sticky; onread = rclr;} checksum_error [ 1] = 0;
         } error;
         reg {
             field {sw = r; hw = w;} clk_btw_pps [32] = 0;
         } clk_btw_pps;
     } status_registers;
 
     reg {
         field {singlepulse = true; reset = 1'b0; sw = w; hw = r;} pulse_rst = 0;
         field {sw = rw; hw = r;} toggle_rst = 0;
     } rst;

  regfile {
         default sw = rw;   
         default hw = rw;
         reg {
             field {sw = rw; hw = r;} max_count [32] = 0;
         } max_count;
         reg {
             field {sticky; } maxcntr_enable [ 1] = 0;
         } sw_maxcntr_enable;
     } ctrl_logic_registers;


};

